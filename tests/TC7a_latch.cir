* uPC1237_SSR.cir — защита АС: uPC1237 + VOM1271 + 2x N-MOSFET (встречно, общие истоки)
* Верификация: nix shell nixpkgs#ngspice -c ngspice -b uPC1237_SSR.cir
* Допущения поведенческой модели uPC1237 см. README.md. Модель VOM1271: I_ph=1.5e-3*I(D_LED), VOC=8.4 В, R_off=140 кОм.
*=========================================================== ПАРАМЕТРЫ (agent C: заменить на выбранную деталь)
*.param CISS=5.3n    RD=0.85m RS=0.85m KP=200   VTO=2.8   RG=1.6
*  MOSFET IAUC120N06S5N015: Rds(on) = 1/(KP*(Vgs-VTO)) + RD + RS = 1.0m + 1.7m = 2.7 мОм при 100 C <= 10 мОм
.param RDS_KEY=2.7m
* uPC1237 / VOM1271 / времязадающие
* Все параметры ниже реально используются в элементах (правка .param меняет схему).
.param R08=15k   V8Z=3.4   VTH7=2.06  R07=220k  C07=22u
.param RA=110k   RB=110k   RC=91k    CS_DC=4.7u
.param R04=24k   C04=3.3u  RINT4=15k VTH4=0.74  VTH1=0.67  VTH2P=0.62 VTH2N=-0.17
* R_LED для ветви LED(VOM1271) + LED(OPT1): (12 - 1.4 - 1.2)/11.5 мА = 820 Ом (E24)
.param LATCH_HOLD=1
.param RLIM=820   VHLOG=12  VOC=8.4   IPHA=1.5e-3  R_OFF=140k  CIO=200p
*=========================================================== ПИТАНИЕ И СЕТЬ
VCC45 VCC45 0 45
R8 VCC45 VCCIC {R08}
D8 0 VCCIC DZ8               ; стабилитрон V8Z (BV в модели DZ8)
VHLOG12 VHLOG 0 {VHLOG}           ; вспомогательный +12 В для светодиода (R5: PIN6 <= 12 В)
VAC  ACR  0 SIN(0 50 50)     ; имитация сетевого напряжения (полуволна, ~40 В rms)
DAC  ACR VACR DRECT          ; однополупериодный выпрямитель
R4   VACR VAC4 {R04}
C4   VAC4 0 2.2u ic=0
RINT4 VAC4 0 15k             ; внутр. сопротивление входа 4 (модель)
*=========================================================== U1: uPC1237 (макромодель)
R7  VCCIC VDLY {R07}
C7  VDLY 0 {C07} ic=0               ; T_ON = 0.931*R7*C7 = 4.5 с
RA1 AMP_OUT N2 {RA}
RB1 N2 0 {RB}
RC1 N2 0 {RC}
C2  N2 0 {CS_DC} ic=0             ; T_DC = RC-фильтр детекции DC
* Ic2 = 12.5 мкА учитывается АНАЛИТИЧЕСКИ по формулам (1)-(3) даташита, в модель не введён
* (иначе ложный сдвиг рабочей точки: нелинейный ток входа вывода 2 удерживал бы узел при v<0)
* Внешний детектор перегрузки: RC-фильтр (10 кОм + 1 нФ, tau=10 мкс) — и физично (вход вывода 1
* имеет RC), и снимает численную петлю «ток -> срабатывание -> S6 -> ток» (Timestep too small на 20 А).
BOVL VOVLX 0 V = { 0.67*(abs(i(VIOUT))/5) }
ROVL VOVLX VOVL 10k
COVL VOVL 0 1n
C3  VLATCH 0 0.022u ic=0          ; вывод 3: latch (0.022 мкФ на GND)
* Вывод 3 = триггер: авария ВЗВОДИТ защёлку, а при LATCH_HOLD=1 она самоподхватывается
* (в даташите это flip-flop; при LATCH_HOLD=0 — auto-reset: держится только пока есть авария).
BCHG 0 VLATCH I = { (((v(VFLT)>2.5)?1:0) + ((LATCH_HOLD>0.5)?((v(VLATCH)>0.5)?1:0):0)) > 0 ? (5-v(VLATCH))/2.2k : 0 }
* Признак аварии (0/5 В), идущий в latch: DC-offset (вывод 2) ИЛИ перегрузка (вывод 1).
* AC-OFF (вывод 4) в latch НЕ заводится — по даташиту это gating-функция (см. README).
BS1 VFLT 0 V = 5*(((v(N2)>VTH2P)?1:0) + ((v(N2)<VTH2N)?1:0) + ((v(VOVL)>VTH1)?1:0) > 0 ? 1 : 0)
RLEAK VLATCH 0 1G            ; latch: утечка 1 ГОм; auto-reset: 10 кОм (вариант TC7b)
* Логика вывода 6: задержка T_ON И нет аварии И нет защёлки И сеть присутствует (VAC4 > 0.74 В)
BLOGIC LOGIC 0 V = { 5*(((v(VDLY)>VTH7)?1:0) * ((v(VFLT)<2.5)?1:0) * ((v(VLATCH)<2.5)?1:0) * ((v(VAC4)>VTH4)?1:0)) }
S6 PIN6 0 LOGIC 0 SW6        ; вывод 6: открытый коллектор (насыщен = норма)
CPIN6 PIN6 0 100p ic=0       ; ёмкость проводников/LED (сглаживает узел вывода 6)
.model SW6 SW(Ron=30 Roff=1e12 Vt=2.5 Vh=0.3)
*=========================================================== СВЕТОДИОДНАЯ ВЕТВЬ
RLED VHLOG LED_A {RLIM}
VLEDS LED_A LED_A2 0         ; датчик тока светодиода (0 В)
DLED LED_A2 PIN6 DL1         ; ЭКВИВАЛЕНТ двух последовательных светодиодов (VOM1271 + оптопара OPT1):
*                              VF(суммарн.) = 2.6 В при 11.5 мА; одним диодом — чтобы не создавать
*                              плавающий узел между двумя LED (иначе ngspice: Timestep too small)
*=========================================================== U2: VOM1271 (вторичная сторона)
Bph VION VIOP I = { IPHA*i(VLEDS) * (1-exp((v(VIOP)-v(VION)-VOC)/0.35)) }
Cio VIOP VION {CIO}
VSEC VION CS 0               ; подключение минуса вторичной стороны к общим истокам (CS)
BOFF VOFF 0 V = { ((i(VLEDS))<0.5m ? 5 : 0) }
SOFF VIOP VION VOFF 0 SWOFF  ; встроенная цепь быстрого выключения (R_off ~ 140 кОм)
.model SWOFF SW(Ron={R_OFF} Roff=1e12 Vt=2.5 Vh=0.5)
*=========================================================== КЛЮЧ (общие истоки)
RG1 VIOP GATE1 100
RG2 VIOP GATE2 100
* RGS: 10 МОм (а не 1 МОм): при ISC~15 мкА VOM1271 нагрузка 0.5 МОм просаживала
* Vgs до ~7.3 В, т.е. ниже гарантированного R1 диапазона 7.8..8.4 В. 10 МОм -> Vgs ~= VOC.
CGS1 GATE1 CS 47n          ; затвор-исток: делитель против drain-induced turn-on (Cgd-наводка при фронте стока)
RGS1 GATE1 CS 10Meg
CGS2 GATE2 CS 47n
RGS2 GATE2 CS 10Meg
* Активный разряд затвора (R11, OPT1 в BOM): управляется ТОК СВЕТОДИОДА (первичная сторона, через
* развязку) — тот же сигнал, что включает встроенную цепь VOM1271. LED горит = разряд выключен;
* LED погас (любая причина: авария, нет сети, обрыв) = затвор стягивается на CS через 50 Ом.
* Даёт t_off ~мкс для ЛЮБОЙ аварии и не создаёт алгебраической петли с детекторами (в отличие от
* управления по LOGIC — там на 20 А ловился Timestep too small). Инверсии R3 нет.
BDIS DIS 0 V = { ((i(VLEDS) > 0.5m) ? 0 : 5) }
SDIS1 GATE1 CS DIS 0 SWDIS
SDIS2 GATE2 CS DIS 0 SWDIS
* Ron=5 Ом (реальный ключ: P-MOSFET BSS84 ~1 Ом + последовательные 4.7 Ом).
* ВАЖНО: 50 Ом давали ложный повторный ОТКРЫВ ключа через Cgd при фронте стока 50 В
* (drain-induced turn-on): импульс тока 1 нФ * dV/dt = 50 мА создавал на 50 Ом ~2.5 В на затворе,
* ключ уходил в линейный режим, и энергия выключения вырастала до 0.42 Дж (TC9). С 5 Ом — 0.25 В.
.model SWDIS SW(Ron=5 Roff=1e12 Vt=2.5 Vh=0.5)
* OPT2 — ОБЯЗАТЕЛЕН: ограничитель выброса через ключ. АС — индуктивная нагрузка (0.3…1 мГ),
* и при быстром размыкании (активный разряд) ЭДС L*dI/dt даёт киловольты: без ограничителя
* ключ 60 В уходит в лавину (измерено в TC13a: 3784 В на 0.5 мГ / 5.2 А).
* Два стабилитрона встречно: ограничение ~BV + прямое падение ≈ 52 В < 60 В (запас 12 %).
* ВАЖНО: пара стабилитронов включается ВСТРЕЧНО С ОБЩИМ АНОДОМ на CS (катоды — на стоки).
* Цепочка «анод-катод-анод» (ошибка) давала в одном направлении диод с падением 1.4 В — то есть
* ограничитель КОРОТИЛ ключ в обратной полярности и блокировка терялась (ловится тестом TC18).
* Правило выбора: Vclamp < 0.9 * Vds(MOSFET), Vclamp > (напряжение рельсов + 15 %) И энергия
* поглощения >= 0.5 Дж (у реального динамика Le = 0.3...2 мГ, ток аварии до 15...20 А => до 0.1...0.4 Дж).
DTVS1 CS AMP_OUT DTVS
DTVS2 CS SPK DTVS
.model DTVS D(Is=1e-12 N=1.2 Rs=0.5 BV=51 IBV=10m)
BVSW VSW 0 V = { ((v(AMP_OUT)-v(SPK)) > 0) ? (v(AMP_OUT)-v(SPK)) : (v(SPK)-v(AMP_OUT)) }
M1 AMP_OUT GATE1 CS M_SSR
M2 SPK GATE2 CS M_SSR
*=========================================================== ВЫХОДНОЙ КАСКАД УМ (фиксированная часть)
VAMP AMPIN 0 PWL(0 0 5 0 5.001 3 6.5 3 6.501 0)            ; сценарий может подменить эту строку (PWL)
ROUT AMPIN ROUTX 10m
VIOUT ROUTX AMP_OUT 0        ; датчик тока выхода УМ (= ток ключа)
*<<<SCENARIO
VSNS SPK SPKX 0
RLOAD SPKX 0 8
*>>>SCENARIO
*=========================================================== МОДЕЛИ
.model DZ8 D(Is=1e-14 N=1.5 Rs=10 BV={V8Z} IBV=1m)
.model DRECT D(Is=1e-14 N=1.2 Rs=1)
* DL1 = эквивалент двух последовательных светодиодов: 2.6 В при 11.5 мА
.model DL1 D(Is=2.2e-21 N=2.29 Rs=5)
* MAIN: Infineon IAUC120N06S5N015 (60 В, PG-TDSON-8). Происхождение параметров — models/MOSFET_CHOICE.md, models/cards.model
.model M_SSR      VDMOS(Ron=2.7m Rd=0.85m Rs=0.85m Kp=200 Vto=2.8 Cgs=5.3n Cgdmax=1n  Cgdmin=56p  Cjo=3n   Rg=1.6 Qg=73.7n mfg=Infineon Vds=60)
* РЕЗЕРВ: Vishay SUM50020EL (TO-263)
.model M_SSR_BKP  VDMOS(Ron=3.0m Rd=1.0m  Rs=1.0m  Kp=175 Vto=2.0 Cgs=10.6n Cgdmax=1.9n Cgdmin=475p Cjo=1.5n Rg=1.6 Qg=126n  mfg=Vishay   Vds=60)
.options reltol=1e-4 abstol=1e-10 vntol=1e-7 itl4=200
.temp 27
.tran 20u 9 0 20u uic

* Vgs измеряется ДИФФЕРЕНЦИАЛЬНО: в закрытом состоянии вся вторичная сторона (VIOP/VION/CS/GATE)
* плавает, и абсолютное v(GATE1) не имеет смысла (может быть -1 В при полностью закрытом ключе).
.meas tran vg_fault FIND v(GATE1) AT=6.0
.meas tran vcs_fault FIND v(CS) AT=6.0
.meas tran vgs_fault PARAM='vg_fault-vcs_fault'
.meas tran vg_after FIND v(GATE1) AT=8.8
.meas tran vcs_after FIND v(CS) AT=8.8
.meas tran vgs_after PARAM='vg_after-vcs_after'
.meas tran vlatch_after FIND v(VLATCH) AT=8.8

.end
